ADE simulation setup
Test PA_design_PA_test_1: PA_design/PA_test/schematic, simulator spectre
  Models: /esat/micas-data/data/design/generic/045/gpdk045_v_4_0/gpdk045/../models/spectre/gpdk045.scs[mc]
  Temperature: 27
  Analysis sp: start=1G stop=100G lin=100 ports=("/PORT0" "/PORT1")
  Analysis dc: (saves the operating point)
  Output S21 dB20 = db(spm('sp 2 1))
  Output Gmax dB10 = db10(gmax(sp(1 1 ?result "sp") sp(1 2 ?result "sp") sp(2 1 ?result "sp") sp(2 2 ?result "sp")))
  Output Kf = kf(sp(1 1 ?result "sp") sp(1 2 ?result "sp") sp(2 1 ?result "sp") sp(2 2 ?result "sp"))
  Output B1f = b1f(sp(1 1 ?result "sp") sp(1 2 ?result "sp") sp(2 1 ?result "sp") sp(2 2 ?result "sp"))
Run mode: Single Run, Sweeps and Corners
Setup values for test PA_design_PA_test_1: r = 10; frf = 24G; prf = 0; rho = 0; phi = 0; cin = 62.9f; cout = 86f; lin = 250p; lout = 449p
