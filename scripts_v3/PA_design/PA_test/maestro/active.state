ADE simulation setup
Test PA_design_PA_test_1: PA_design/PA_test/schematic, simulator spectre
  Models: /esat/micas-data/data/design/generic/045/gpdk045_v_4_0/gpdk045/../models/spectre/gpdk045.scs[mc]
  Variables: r = 3; frf = 24G; prf = 0; rho = 0; phi = 0; lin2 = 112p; cin = 570f; lin = 135p; lout2 = 134p; cout = 474f; lout = 103p; w = 1u
  Temperature: 27
  Analysis sp: start=1G stop=100G lin=100 ports=("/PORT0" "/PORT1")
  Analysis dc: (saves the operating point)
  Analysis pss: sweep prf start=-25 stop=25 sweepStep=1 engine=Harmonic Balance fund=24G harms=7 errpreset=moderate
  Output S21 dB20 = db(spm('sp 2 1))
  Output Gmax dB10 = db10(gmax(sp(1 1 ?result "sp") sp(1 2 ?result "sp") sp(2 1 ?result "sp") sp(2 2 ?result "sp")))
  Output Kf = kf(sp(1 1 ?result "sp") sp(1 2 ?result "sp") sp(2 1 ?result "sp") sp(2 2 ?result "sp"))
  Output B1f = b1f(sp(1 1 ?result "sp") sp(1 2 ?result "sp") sp(2 1 ?result "sp") sp(2 2 ?result "sp"))
  Output ZM 1 reOhms = real(zm(1 ?result "sp"))
  Output ZM 1 imOhms = imag(zm(1 ?result "sp"))
  Output ZM 2 reOhms = real(zm(2 ?result "sp"))
  Output ZM 2 imOhms = imag(zm(2 ?result "sp"))
  Output Output Referred 1dB Compression Point = compressionVRI((v("/net7" ?result "pss_fd") - 0.0) '1 ?rport resultParam("PORT1:r" ?result "pss_fd") ?gcomp 1 ?measure "Output")
  Output 1st Order freq = "cadar(setof(x harmonicFreqList(?result \"pss_fd\") equal(car(x) '1)))" (unticked)
  Output compressionCurves = compressionVRICurves((v("/net5" ?result "pss_fd") - 0.0) '1 ?rport resultParam("PORT1:r" ?result "pss_fd") ?gcomp 1)
  Output Constant Power Contours = cPwrContour(i("/PORT1/PLUS" ?result "pss_fd") v("/net5" ?result "pss_fd") '1 ?minPower 0 ?refImp 50.0 ?numCont 9 ?modifier "dBm")
  Output S11 dB20 = db(spm('sp 1 1))
  Output 100.*(p(/PORT1/PLUS /net5)-p(/PORT0/PLUS /net1))/Pdc(1)  pss P/P = ((100.0 * harmonic((spectralPower(i("/PORT1/PLUS" ?result "pss_fd") v("/net5" ?result "pss_fd")) + spectralPower(i("/PORT0/PLUS" ?result "pss_fd") v("/net1" ?result "pss_fd"))) '(1))) / (- harmonic(spectralPower(i("/V2/PLUS" ?result "pss_fd") v("/net7" ?result "pss_fd")) '(0))))
Run mode: Single Run, Sweeps and Corners
Setup values for test PA_design_PA_test_1: r = 10; cin = 62.9f; cout = 86f; lin = 250p; lout = 449p
