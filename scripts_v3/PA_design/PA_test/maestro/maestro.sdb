ADE simulation setup
Run mode: Single Run, Sweeps and Corners
Tests:
  PA_design_PA_test_1: PA_design/PA_test/schematic, simulator spectre
    Variables: r = 6; frf = 24G; prf = 5; rho = 0; phi = 0; lin2 = 146p; cin = 369f; lin = 151p; lout2 = 124p; cout = 526f; lout = 137p; w = 1u; q = 30
Specs:
  PA_design_PA_test_1 / Kf: > 1
  PA_design_PA_test_1 / B1f: > 0
