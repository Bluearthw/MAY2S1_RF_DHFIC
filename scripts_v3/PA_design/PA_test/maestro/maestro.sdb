ADE simulation setup
Run mode: Single Run, Sweeps and Corners
Tests:
  PA_design_PA_test_1: PA_design/PA_test/schematic, simulator spectre
