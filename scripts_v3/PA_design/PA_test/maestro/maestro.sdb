ADE simulation setup
Run mode: Single Run, Sweeps and Corners
Tests:
  PA_design_PA_test_1: PA_design/PA_test/schematic, simulator spectre
    Variables: r = 10; frf = 24G; prf = 0; rho = 0; phi = 0; cin = 62.9f; cout = 86f; lin = 250p; lout = 449p
