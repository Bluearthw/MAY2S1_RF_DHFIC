ADE simulation setup
Run mode: Single Run, Sweeps and Corners
Tests:
  PA_design_PA_test_1: PA_design/PA_test/schematic, simulator spectre
    Variables: r = 1; frf = 24G; prf = 0; rho = 0; phi = 0; lin2 = 133p; cin = 545f; lin = 43.1p; lout = 124p; cout = 532f; lout2 = 145p; w = 1u
